////////////////////////////////////////////////////////////////////////////////////////////////////////////////////////////////////////////////////////////////////////////////////////////////////
//Copyright @ 2014 The Pennsylvania State University (Penn State).
//The terms under which the software and associated documentation (the Software) is provided are as the following:
//The Software is provided "as is", without warranty of any kind, express or implied, including but not limited to the warranties of merchantability, fitness for a particular purpose and noninfringement. In no event shall the authors or copyright holders be liable for any claim, damages or other liability, whether in an action of contract, tort or otherwise, arising from, out of or in connection with the Software or the use or other dealings in the Software.
//Penn State and NEEDS grants, free of charge, to any users the right to modify, copy, and redistribute the Software, both within the user's organization and externally, subject to the following restrictions:
//1. The users agree not to charge for the code itself but may charge for additions, extensions, or support.

//2. In any product based on the Software, the users agree to acknowledge the Research Group that developed the software. This acknowledgment shall appear in the product documentation.

//3. The users agree to obey all U.S. Government restrictions governing redistribution or export of the software.

//4. The users agree to reproduce any copyright notice which appears on the software on any copy or modification of such made available to others.

//Agreed to by
//Suman Datta, Penn State
//March 28, 2014
////////////////////////////////////////////////////////////////////////////////////////////////////////////////////////////////////////////////////////////////////////////////////////////////////
/////////////////////////////////////////////////////////////////////////////////////////////////////////////////////////////////////////////////////////////////////////////////////////////////////
//VerilogA for double-gate GaSb-InAs Heterojunction Tunnel FET model based on lookup tables, which employs the current and capacitance characteristics from calibrated TCAD Sentaurus Simulations
//Model details: V. Saripalli et al IEEE/ACM NanoArch 2011.
//Original Model Developed by V. Saripalli
//Implemented by H. Liu
////////////////////////////////////////////////////////////////////////////////////////////////////////////////////////////////////////////////////////////////////////////////////////////////
`define _HETEROJUNCTION_
`include "tfet_master.va"
